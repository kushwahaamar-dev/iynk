* C10 Red LED straight on D13, no resistor (first solve, before it burns) (realistic)
Vsrc_D13 s_d13 0 5.00000000000000
Rsrc_D13 s_d13 n_d13 25
Vs_led1 n_d13 x_led1 0
D_led1 x_led1 0 DLED_led1
.model DLED_led1 D(IS=3.852706e-19 N=2 RS=0.5)
.options reltol=1e-9 abstol=1e-14 vntol=1e-9 itl1=500 gmin=1e-12
.op
.end
