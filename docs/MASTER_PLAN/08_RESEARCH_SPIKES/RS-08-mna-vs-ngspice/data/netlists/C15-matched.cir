* C15 TIP120 low-side motor switch, 1k base from D6, motor on 5V, flyback diode (matched)
Vsrc_D6 s_d6 0 5.00000000000000
Rsrc_D6 s_d6 n_d6 25
Vsrc_5V s_5v 0 4.95000000000000
Rsrc_5V s_5v n_5v 0.5
R_r1 n_d6 n_b 1000
Vsb_q1 n_b bi_q1 0
Vsc_q1 n_c ci_q1 0
Bb_q1 bi_q1 0 I=max(V(bi_q1,0)-1.3,0)/2
Bc_q1 ci_q1 0 I=max(min(1000*max(V(bi_q1,0)-1.3,0)/2,(V(ci_q1,0)-0.9)/0.01),0)
Vs_mot1 n_5v x_mot1 0
B_mot1 x_mot1 n_c I=pwl(V(x_mot1,n_c),-10.0,-0.579874758425663,0.00000000000000,0.00000000000000,0.0200000000000000,0.0139860139860140,0.0400000000000000,0.0279720279720280,0.0600000000000000,0.0419580419580420,0.0800000000000000,0.0559440559440560,0.100000000000000,0.0699300699300699,0.120000000000000,0.0839160839160839,0.140000000000000,0.0979020979020979,0.160000000000000,0.111888111888112,0.180000000000000,0.125874125874126,0.200000000000000,0.139860139860140,0.220000000000000,0.153846153846154,0.240000000000000,0.167832167832168,0.260000000000000,0.181818181818182,0.280000000000000,0.195804195804196,0.300000000000000,0.209790209790210,0.320000000000000,0.223776223776224,0.340000000000000,0.237762237762238,0.360000000000000,0.251748251748252,0.380000000000000,0.265734265734266,0.400000000000000,0.279720279720280,0.420000000000000,0.293706293706294,0.440000000000000,0.307692307692308,0.460000000000000,0.321678321678322,0.480000000000000,0.335664335664336,0.500000000000000,0.349650349650350,0.520000000000000,0.363636363636364,0.540000000000000,0.377622377622378,0.560000000000000,0.391608391608392,0.580000000000000,0.405594405594406,0.600000000000000,0.120996852693328,0.620000000000000,0.121091764120295,0.640000000000000,0.121190959497784,0.660000000000000,0.121294434864787,0.680000000000000,0.121402186266399,0.700000000000000,0.121514209753798,0.720000000000000,0.121630501384238,0.740000000000000,0.121751057221035,0.760000000000000,0.121875873333551,0.780000000000000,0.122004945797183,0.800000000000000,0.122138270693351,0.820000000000000,0.122275844109484,0.840000000000000,0.122417662139006,0.860000000000000,0.122563720881325,0.880000000000000,0.122714016441820,0.900000000000000,0.122868544931826,0.920000000000000,0.123027302468624,0.940000000000001,0.123190285175427,0.960000000000001,0.123357489181369,0.980000000000001,0.123528910621487,1.00000000000000,0.123704545636717,1.02000000000000,0.123884390373873,1.04000000000000,0.124068440985639,1.06000000000000,0.124256693630557,1.08000000000000,0.124449144473011,1.10000000000000,0.124645789683220,1.12000000000000,0.124846625437217,1.14000000000000,0.125051647916848,1.16000000000000,0.125260853309750,1.18000000000000,0.125474237809341,1.20000000000000,0.125691797614814,1.22000000000000,0.125913528931114,1.24000000000000,0.126139427968935,1.26000000000000,0.126369490944705,1.28000000000000,0.126603714080571,1.30000000000000,0.126842093604390,1.32000000000000,0.127084625749716,1.34000000000000,0.127331306755788,1.36000000000000,0.127582132867520,1.38000000000000,0.127837100335483,1.40000000000000,0.128096205415901,1.42000000000000,0.128359444370633,1.44000000000000,0.128626813467165,1.46000000000000,0.128898308978594,1.48000000000000,0.129173927183621,1.50000000000000,0.129453664366536,1.52000000000000,0.129737516817207,1.54000000000000,0.130025480831069,1.56000000000000,0.130317552709111,1.58000000000000,0.130613728757866,1.60000000000000,0.130914005289398,1.62000000000000,0.131218378621291,1.64000000000000,0.131526845076636,1.66000000000000,0.131839400984023,1.68000000000000,0.132156042677527,1.70000000000000,0.132476766496695,1.72000000000000,0.132801568786537,1.74000000000000,0.133130445897516,1.76000000000000,0.133463394185533,1.78000000000000,0.133800410011917,1.80000000000000,0.134141489743413,1.82000000000000,0.134486629752175,1.84000000000000,0.134835826415749,1.86000000000000,0.135189076117065,1.88000000000000,0.135546375244423,1.90000000000000,0.135907720191487,1.92000000000000,0.136273107357270,1.94000000000000,0.136642533146120,1.96000000000000,0.137015993967718,1.98000000000000,0.137393486237058,2.00000000000000,0.137775006374440,2.02000000000000,0.138160550805460,2.04000000000000,0.138550115960994,2.06000000000000,0.138943698277196,2.08000000000000,0.139341294195476,2.10000000000000,0.139742900162499,2.12000000000000,0.140148512630167,2.14000000000000,0.140558128055615,2.16000000000000,0.140971742901192,2.18000000000000,0.141389353634458,2.20000000000000,0.141810956728168,2.22000000000000,0.142236548660264,2.24000000000000,0.142666125913863,2.26000000000000,0.143099684977248,2.28000000000000,0.143537222343855,2.30000000000000,0.143978734512265,2.32000000000000,0.144424217986191,2.34000000000000,0.144873669274470,2.36000000000000,0.145327084891049,2.38000000000000,0.145784461354978,2.40000000000000,0.146245795190399,2.42000000000000,0.146711082926533,2.44000000000000,0.147180321097673,2.46000000000000,0.147653506243171,2.48000000000000,0.148130634907428,2.50000000000000,0.148611703639887,2.52000000000000,0.149096708995018,2.54000000000000,0.149585647532311,2.56000000000000,0.150078515816262,2.58000000000000,0.150575310416369,2.60000000000000,0.151076027907116,2.62000000000000,0.151580664867966,2.64000000000000,0.152089217883349,2.66000000000000,0.152601683542654,2.68000000000000,0.153118058440218,2.70000000000000,0.153638339175314,2.72000000000000,0.154162522352144,2.74000000000000,0.154690604579828,2.76000000000000,0.155222582472394,2.78000000000000,0.155758452648766,2.80000000000000,0.156298211732758,2.82000000000000,0.156841856353061,2.84000000000000,0.157389383143234,2.86000000000000,0.157940788741695,2.88000000000000,0.158496069791711,2.90000000000000,0.159055222941386,2.92000000000000,0.159618244843654,2.94000000000000,0.160185132156270,2.96000000000000,0.160755881541795,2.98000000000000,0.161330489667592,3.00000000000000,0.161908953205815,3.02000000000000,0.162491268833397,3.04000000000000,0.163077433232042,3.06000000000000,0.163667443088217,3.08000000000000,0.164261295093138,3.10000000000000,0.164858985942767,3.12000000000000,0.165460512337795,3.14000000000000,0.166065870983639,3.16000000000000,0.166675058590429,3.18000000000000,0.167288071872999,3.20000000000000,0.167904907550878,3.22000000000000,0.168525562348281,3.24000000000000,0.169150032994100,3.26000000000000,0.169778316221891,3.28000000000000,0.170410408769872,3.30000000000000,0.171046307380905,3.32000000000000,0.171686008802494,3.34000000000000,0.172329509786771,3.36000000000000,0.172976807090490,3.38000000000000,0.173627897475014,3.40000000000000,0.174282777706311,3.42000000000000,0.174941444554940,3.44000000000000,0.175603894796046,3.46000000000000,0.176270125209345,3.48000000000000,0.176940132579123,3.50000000000000,0.177613913694221,3.52000000000000,0.178291465348026,3.54000000000000,0.178972784338466,3.56000000000000,0.179657867467998,3.58000000000000,0.180346711543598,3.60000000000000,0.181039313376756,3.62000000000000,0.181735669783463,3.64000000000000,0.182435777584206,3.66000000000000,0.183139633603955,3.68000000000000,0.183847234672156,3.70000000000000,0.184558577622725,3.72000000000000,0.185273659294034,3.74000000000000,0.185992476528905,3.76000000000000,0.186715026174603,3.78000000000000,0.187441305082822,3.80000000000000,0.188171310109682,3.82000000000000,0.188905038115717,3.84000000000000,0.189642485965867,3.86000000000000,0.190383650529471,3.88000000000000,0.191128528680255,3.90000000000000,0.191877117296325,3.92000000000000,0.192629413260160,3.94000000000000,0.193385413458603,3.96000000000000,0.194145114782848,3.98000000000000,0.194908514128440,4.00000000000000,0.195675608395256,4.02000000000000,0.196446394487507,4.04000000000000,0.197220869313721,4.06000000000000,0.197999029786741,4.08000000000000,0.198780872823712,4.10000000000000,0.199566395346074,4.12000000000000,0.200355594279556,4.14000000000000,0.201148466554163,4.16000000000000,0.201945009104173,4.18000000000000,0.202745218868124,4.20000000000000,0.203549092788808,4.22000000000000,0.204356627813263,4.24000000000000,0.205167820892765,4.26000000000000,0.205982668982816,4.28000000000000,0.206801169043142,4.30000000000000,0.207623318037681,4.32000000000000,0.208449112934572,4.34000000000000,0.209278550706155,4.35999999999999,0.210111628328954,4.37999999999999,0.210948342783677,4.39999999999999,0.211788691055201,4.41999999999999,0.212632670132567,4.43999999999999,0.213480277008974,4.45999999999999,0.214331508681766,4.47999999999999,0.215186362152428,4.49999999999999,0.216044834426578,4.51999999999999,0.216906922513955,4.53999999999999,0.217772623428418,4.55999999999999,0.218641934187929,4.57999999999999,0.219514851814554,4.59999999999999,0.220391373334449,4.61999999999999,0.221271495777855,4.63999999999999,0.222155216179090,4.65999999999999,0.223042531576540,4.67999999999999,0.223933439012651,4.69999999999999,0.224827935533923,4.71999999999999,0.225726018190902,4.73999999999999,0.226627684038170,4.75999999999999,0.227532930134339,4.77999999999999,0.228441753542044,4.79999999999999,0.229354151327933,4.81999999999999,0.230270120562661,4.83999999999998,0.231189658320884,4.85999999999998,0.232112761681246,4.87999999999998,0.233039427726377,4.89999999999998,0.233969653542883,4.91999999999998,0.234903436221338,4.93999999999998,0.235840772856276,4.95999999999998,0.236781660546188,4.97999999999998,0.237726096393506,4.99999999999998,0.238674077504605,5.01999999999998,0.239625600989787,5.03999999999998,0.240580663963281,5.05999999999998,0.241539263543230,5.07999999999998,0.242501396851685,5.09999999999998,0.243467061014600,5.11999999999998,0.244436253161821,5.13999999999998,0.245408970427081,5.15999999999998,0.246385209947994,5.17999999999998,0.247364968866042,5.19999999999998,0.248348244326573,5.21999999999998,0.249335033478794,5.23999999999998,0.250325333475758,5.25999999999998,0.251319141474364,5.27999999999998,0.252316454635343,5.29999999999997,0.253317270123257,5.31999999999997,0.254321585106486,5.33999999999997,0.255329396757225,5.35999999999997,0.256340702251476,5.37999999999997,0.257355498769039,5.39999999999997,0.258373783493505,5.41999999999997,0.259395553612253,5.43999999999997,0.260420806316438,5.45999999999997,0.261449538800984,5.47999999999997,0.262481748264582,5.49999999999997,0.263517431909677,5.51999999999997,0.264556586942464,5.53999999999997,0.265599210572881,5.55999999999997,0.266645300014602,5.57999999999997,0.267694852485028,5.59999999999997,0.268747865205281,5.61999999999997,0.269804335400200,5.63999999999997,0.270864260298330,5.65999999999997,0.271927637131916,5.67999999999997,0.272994463136898,5.69999999999997,0.274064735552901,5.71999999999997,0.275138451623232,5.73999999999997,0.276215608594871,5.75999999999997,0.277296203718462,5.77999999999996,0.278380234248310,5.79999999999996,0.279467697442372,5.81999999999996,0.280558590562252,5.83999999999996,0.281652910873192,5.85999999999996,0.282750655644066,5.87999999999996,0.283851822147373,5.89999999999996,0.284956407659232,5.91999999999996,0.286064409459373,5.93999999999996,0.287175824831133,5.95999999999996,0.288290651061445,5.97999999999996,0.289408885440835,5.99999999999996,0.290530525263417,6.01999999999996,0.291655567826879,6.03999999999996,0.292784010432483,6.05999999999996,0.293915850385059,6.07999999999996,0.295051084992992,6.09999999999996,0.296189711568221,6.11999999999996,0.297331727426231,6.13999999999996,0.298477129886045,6.15999999999996,0.299625916270220,6.17999999999996,0.300778083904837,6.19999999999996,0.301933630119500,6.21999999999996,0.303092552247324,6.23999999999995,0.304254847624929,6.25999999999995,0.305420513592439,6.27999999999995,0.306589547493468,6.29999999999995,0.307761946675121,6.31999999999995,0.308937708487982,6.33999999999995,0.310116830286109,6.35999999999995,0.311299309427028,6.37999999999995,0.312485143271730,6.39999999999995,0.313674329184657,6.41999999999995,0.314866864533704,6.43999999999995,0.316062746690206,6.45999999999995,0.317261973028937,6.47999999999995,0.318464540928098,6.49999999999995,0.319670447769318,6.51999999999995,0.320879690937640,6.53999999999995,0.322092267821522,6.55999999999995,0.323308175812823,6.57999999999995,0.324527412306805,6.59999999999995,0.325749974702121,6.61999999999995,0.326975860400810,6.63999999999995,0.328205066808293,6.65999999999995,0.329437591333365,6.67999999999995,0.330673431388188,6.69999999999995,0.331912584388288,6.71999999999994,0.333155047752545,6.73999999999994,0.334400818903189,6.75999999999994,0.335649895265796,6.77999999999994,0.336902274269278,6.79999999999994,0.338157953345878,6.81999999999994,0.339416929931166,6.83999999999994,0.340679201464030,6.85999999999994,0.341944765386674,6.87999999999994,0.343213619144607,6.89999999999994,0.344485760186641,6.91999999999994,0.345761185964883,6.93999999999994,0.347039893934730,6.95999999999994,0.348321881554863,6.97999999999994,0.349607146287241,6.99999999999994,0.350895685597093,7.01999999999994,0.352187496952915,7.03999999999994,0.353482577826465,7.05999999999994,0.354780925692752,7.07999999999994,0.356082538030035,7.09999999999994,0.357387412319816,7.11999999999994,0.358695546046832,7.13999999999994,0.360006936699053,7.15999999999994,0.361321581767672,7.17999999999993,0.362639478747102,7.19999999999993,0.363960625134970,7.21999999999993,0.365285018432110,7.23999999999993,0.366612656142557,7.25999999999993,0.367943535773546,7.27999999999993,0.369277654835497,7.29999999999993,0.370615010842018,7.31999999999993,0.371955601309897,7.33999999999993,0.373299423759093,7.35999999999993,0.374646475712734,7.37999999999993,0.375996754697109,7.39999999999993,0.377350258241665,7.41999999999993,0.378706983878997,7.43999999999993,0.380066929144849,7.45999999999993,0.381430091578101,7.47999999999993,0.382796468720769,7.49999999999993,0.384166058117996,7.51999999999993,0.385538857318048,7.53999999999993,0.386914863872310,7.55999999999993,0.388294075335277,7.57999999999993,0.389676489264550,7.59999999999993,0.391062103220830,7.61999999999993,0.392450914767916,7.63999999999993,0.393842921472693,7.65999999999992,0.395238120905132,7.67999999999992,0.396636510638283,7.69999999999992,0.398038088248268,7.71999999999992,0.399442851314278,7.73999999999992,0.400850797418565,7.75999999999992,0.402261924146439,7.77999999999992,0.403676229086261,7.79999999999992,0.405093709829438,7.81999999999992,0.406514363970417,7.83999999999992,0.407938189106682,7.85999999999992,0.409365182838746,7.87999999999992,0.410795342770146,7.89999999999992,0.412228666507440,7.91999999999992,0.413665151660199,7.93999999999992,0.415104795841001,7.95999999999992,0.416547596665431,7.97999999999992,0.417993551752068,7.99999999999992,0.419442658722487,8.01999999999992,0.420894915201250,8.03999999999992,0.422350318815899,8.05999999999992,0.423808867196956,8.07999999999992,0.425270557977912,8.09999999999992,0.426735388795227,8.11999999999992,0.428203357288322,8.13999999999992,0.429674461099573,8.15999999999991,0.431148697874308,8.17999999999991,0.432626065260800,8.19999999999991,0.434106560910263,8.21999999999991,0.435590182476848,8.23999999999991,0.437076927617634,8.25999999999991,0.438566793992627,8.27999999999991,0.440059779264752,8.29999999999991,0.441555881099851,8.31999999999991,0.443055097166673,8.33999999999991,0.444557425136876,8.35999999999991,0.446062862685013,8.37999999999991,0.447571407488536,8.39999999999991,0.449083057227784,8.41999999999991,0.450597809585983,8.43999999999991,0.452115662249236,8.45999999999991,0.453636612906524,8.47999999999991,0.455160659249694,8.49999999999991,0.456687798973461,8.51999999999991,0.458218029775397,8.53999999999991,0.459751349355931,8.55999999999991,0.461287755418341,8.57999999999991,0.462827245668750,8.59999999999991,0.464369817816120,8.61999999999991,0.465915469572249,8.63999999999990,0.467464198651764,8.65999999999990,0.469016002772121,8.67999999999990,0.470570879653590,8.69999999999990,0.472128827019262,8.71999999999990,0.473689842595036,8.73999999999990,0.475253924109617,8.75999999999990,0.476821069294512,8.77999999999990,0.478391275884022,8.79999999999990,0.479964541615241,8.81999999999990,0.481540864228049,8.83999999999990,0.483120241465107,8.85999999999990,0.484702671071854,8.87999999999990,0.486288150796499,8.89999999999990,0.487876678390021,8.91999999999990,0.489468251606160,8.93999999999990,0.491062868201414,8.95999999999990,0.492660525935033,8.97999999999990,0.494261222569017,8.99999999999990,0.495864955868109,9.01999999999990,0.497471723599791,9.03999999999990,0.499081523534278,9.05999999999990,0.500694353444517,9.07999999999990,0.502310211106177,9.09999999999989,0.503929094297649,9.11999999999989,0.505551000800039,9.13999999999989,0.507175928397164,9.15999999999989,0.508803874875546,9.17999999999989,0.510434838024411,9.19999999999989,0.512068815635681,9.21999999999989,0.513705805503969,9.23999999999989,0.515345805426577,9.25999999999989,0.516988813203491,9.27999999999989,0.518634826637374,9.29999999999989,0.520283843533563,9.31999999999989,0.521935861700067,9.33999999999989,0.523590878947558,9.35999999999989,0.525248893089368,9.37999999999989,0.526909901941487,9.39999999999989,0.528573903322553,9.41999999999989,0.530240895053855,9.43999999999989,0.531910874959321,9.45999999999989,0.533583840865519,9.47999999999989,0.535259790601650,9.49999999999989,0.536938721999543,9.51999999999989,0.538620632893653,9.53999999999989,0.540305521121054,9.55999999999989,0.541993384521436,9.57999999999988,0.543684220937100,9.59999999999988,0.545378028212955,9.61999999999988,0.547074804196511,9.63999999999988,0.548774546737876,9.65999999999988,0.550477253689753,9.67999999999988,0.552182922907432,9.69999999999988,0.553891552248790,9.71999999999988,0.555603139574283,9.73999999999988,0.557317682746945,9.75999999999988,0.559035179632379,9.77999999999988,0.560755628098759,9.79999999999988,0.562479026016819,9.81999999999988,0.564205371259853,9.83999999999988,0.565934661703710,9.85999999999988,0.567666895226790,9.87999999999988,0.569402069710036,9.89999999999988,0.571140183036936,9.91999999999988,0.572881233093514,9.93999999999988,0.574625217768326,9.95999999999988,0.576372134952459,9.97999999999988,0.578121982539524,9.99999999999988,0.579874758425652)
Vs_dio1 n_c x_dio1 0
B_dio1 x_dio1 n_5v I=max(V(x_dio1,n_5v)-0.7,0)/0.2
Rg_d6 n_d6 0 999999999.9999999
Rg_b n_b 0 999999999.9999999
Rg_c n_c 0 999999999.9999999
Rg_5v n_5v 0 999999999.9999999
.options reltol=1e-9 abstol=1e-14 vntol=1e-9 itl1=500 gmin=1e-12
.op
.end
