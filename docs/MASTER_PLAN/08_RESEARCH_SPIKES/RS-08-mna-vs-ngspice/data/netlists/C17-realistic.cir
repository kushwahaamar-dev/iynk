* C17 2N2222 in the active region, 220k base from 5V, 1k load (realistic)
Vsrc_5V s_5v 0 4.95000000000000
Rsrc_5V s_5v n_5v 0.5
R_r1 n_5v n_b 220000
Vsb_q1 n_b bi_q1 0
Vsc_q1 n_c ci_q1 0
Q_q1 ci_q1 bi_q1 0 Q2N
R_r2 n_5v n_c 1000
.model Q2N NPN(IS=5e-15 BF=100 BR=5 VAF=100 RB=10 RC=0.5)
.options reltol=1e-9 abstol=1e-14 vntol=1e-9 itl1=500 gmin=1e-12
.op
.end
