* C02 Three-resistor divider 1k/2.2k/4.7k, two taps (matched)
Vsrc_5V s_5v 0 4.95000000000000
Rsrc_5V s_5v n_5v 0.5
R_r1 n_5v n_a 1000
R_r2 n_a n_b 2200
R_r3 n_b 0 4700
Rg_5v n_5v 0 999999999.9999999
Rg_a n_a 0 999999999.9999999
Rg_b n_b 0 999999999.9999999
.options reltol=1e-9 abstol=1e-14 vntol=1e-9 itl1=500 gmin=1e-12
.op
.end
