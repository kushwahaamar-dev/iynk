* C19 Rail under load: 3V3 rail (0.5 ohm source) into 22 ohm (matched)
Vsrc_3V3 s_3v3 0 3.30000000000000
Rsrc_3V3 s_3v3 n_3v3 0.5
R_r1 n_3v3 0 22
Rg_3v3 n_3v3 0 999999999.9999999
.options reltol=1e-9 abstol=1e-14 vntol=1e-9 itl1=500 gmin=1e-12
.op
.end
