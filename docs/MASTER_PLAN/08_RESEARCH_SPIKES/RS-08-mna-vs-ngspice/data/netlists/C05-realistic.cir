* C05 Wheatstone bridge 1k/2k/2k/3.3k with 10k bridge resistor (realistic)
Vsrc_5V s_5v 0 4.95000000000000
Rsrc_5V s_5v n_5v 0.5
R_r1 n_5v n_a 1000
R_r2 n_a 0 2000
R_r3 n_5v n_b 2000
R_r4 n_b 0 3300
R_r5 n_a n_b 10000
.options reltol=1e-9 abstol=1e-14 vntol=1e-9 itl1=500 gmin=1e-12
.op
.end
