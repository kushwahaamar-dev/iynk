* C03 Divider 1k/1k from a pin (25 ohm source), 1k load on the tap (matched)
Vsrc_D12 s_d12 0 5.00000000000000
Rsrc_D12 s_d12 n_d12 25
R_r1 n_d12 n_a 1000
R_r2 n_a 0 1000
R_r3 n_a 0 1000
Rg_d12 n_d12 0 999999999.9999999
Rg_a n_a 0 999999999.9999999
.options reltol=1e-9 abstol=1e-14 vntol=1e-9 itl1=500 gmin=1e-12
.op
.end
