* C11 Two red LEDs in parallel, one shared 150 ohm (realistic)
Vsrc_D13 s_d13 0 5.00000000000000
Rsrc_D13 s_d13 n_d13 25
R_r1 n_d13 n_a 150
Vs_led1 n_a x_led1 0
D_led1 x_led1 0 DLED_led1
Vs_led2 n_a x_led2 0
D_led2 x_led2 0 DLED_led2
.model DLED_led1 D(IS=3.852706e-19 N=2 RS=0.5)
.model DLED_led2 D(IS=3.852706e-19 N=2 RS=0.5)
.options reltol=1e-9 abstol=1e-14 vntol=1e-9 itl1=500 gmin=1e-12
.op
.end
