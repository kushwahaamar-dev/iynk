* C13 Diode clamp: D13 high through 1k, 1N4007 to the 3V3 rail (matched)
Vsrc_D13 s_d13 0 5.00000000000000
Rsrc_D13 s_d13 n_d13 25
Vsrc_3V3 s_3v3 0 3.30000000000000
Rsrc_3V3 s_3v3 n_3v3 0.5
R_r1 n_d13 n_a 1000
Vs_dio1 n_a x_dio1 0
B_dio1 x_dio1 n_3v3 I=max(V(x_dio1,n_3v3)-0.7,0)/0.2
Rg_d13 n_d13 0 999999999.9999999
Rg_a n_a 0 999999999.9999999
Rg_3v3 n_3v3 0 999999999.9999999
.options reltol=1e-9 abstol=1e-14 vntol=1e-9 itl1=500 gmin=1e-12
.op
.end
