* C13 Diode clamp: D13 high through 1k, 1N4007 to the 3V3 rail (realistic)
Vsrc_D13 s_d13 0 5.00000000000000
Rsrc_D13 s_d13 n_d13 25
Vsrc_3V3 s_3v3 0 3.30000000000000
Rsrc_3V3 s_3v3 n_3v3 0.5
R_r1 n_d13 n_a 1000
Vs_dio1 n_a x_dio1 0
D_dio1 x_dio1 n_3v3 D1N4007
.model D1N4007 D(IS=7.03e-9 N=1.808 RS=0.0342)
.options reltol=1e-9 abstol=1e-14 vntol=1e-9 itl1=500 gmin=1e-12
.op
.end
