* C09 Blue LED, 220 ohm, from 5V rail (matched)
Vsrc_5V s_5v 0 4.95000000000000
Rsrc_5V s_5v n_5v 0.5
R_r1 n_5v n_a 220
Vs_led1 n_a x_led1 0
B_led1 x_led1 0 I=max(V(x_led1,0)-3,0)/0.5
Rg_5v n_5v 0 999999999.9999999
Rg_a n_a 0 999999999.9999999
.options reltol=1e-9 abstol=1e-14 vntol=1e-9 itl1=500 gmin=1e-12
.op
.end
