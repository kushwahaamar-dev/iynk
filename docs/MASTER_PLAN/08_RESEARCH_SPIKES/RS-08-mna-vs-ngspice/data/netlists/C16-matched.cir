* C16 2N2222 saturated, 1k base from D6, 100 ohm load on 5V (matched)
Vsrc_D6 s_d6 0 5.00000000000000
Rsrc_D6 s_d6 n_d6 25
Vsrc_5V s_5v 0 4.95000000000000
Rsrc_5V s_5v n_5v 0.5
R_r1 n_d6 n_b 1000
Vsb_q1 n_b bi_q1 0
Vsc_q1 n_c ci_q1 0
Bb_q1 bi_q1 0 I=max(V(bi_q1,0)-0.7,0)/2
Bc_q1 ci_q1 0 I=max(min(100*max(V(bi_q1,0)-0.7,0)/2,(V(ci_q1,0)-0.2)/0.01),0)
R_r2 n_5v n_c 100
Rg_d6 n_d6 0 999999999.9999999
Rg_b n_b 0 999999999.9999999
Rg_c n_c 0 999999999.9999999
Rg_5v n_5v 0 999999999.9999999
.options reltol=1e-9 abstol=1e-14 vntol=1e-9 itl1=500 gmin=1e-12
.op
.end
